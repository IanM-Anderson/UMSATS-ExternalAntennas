# Ansys Electronics Desktop project, version 2024.2
materials:
  vacuum: permittivity=1
  Carbon Fiber: permittivity=9 conductivity=100000 dielectric_loss_tangent=0.05 delta_H_freq=915000000
  pec: conductivity=1e+30

design HFSSDesign1 (HFSS, HFSS Terminal Network, model units mm)
variables:
  OuterCoaxDiameter = 4.12mm
  RadiatingSurface_Z = 200mm
  RadiatingSurface_X = 300mm
  RadiatingSurface_Y = 200mm
  TubingHeight = 200mm
  TubingRadius = 3in
  TubingThickness = 2mm
  AntennaTubingSpace = 2mm
  InnerCoaxDiameter = 1.12mm
  DielectricCoaxDiameter = 3mm
  AntennaWireRadius = 0.6mm
  Period = 1.1e-09s
  AntennaCoverOffset = AntennaRadius*cos(DipoleLength/AntennaRadius) meter
  SpeedOfLight = 300000000m_per_sec
  DipoleLength = ((SpeedOfLight*Period)/8) meter
  AntennaRadius = TubingRadius + TubingThickness + AntennaTubingSpace
geometry:
  CoaxCover [pec] = cylinder(axis=Z, base_centre=(0in, 0in, 0in), radius=OuterCoaxDiameter/2, height=-2mm)
  RadiatingSurface [vacuum] = box(corner=(-RadiatingSurface_X/2, -RadiatingSurface_Y/2, 0mm), size=(RadiatingSurface_X, RadiatingSurface_Y, RadiatingSurface_Z))
  Tubing [Carbon Fiber, solve inside] = cylinder(axis=Z, base_centre=(0mm, 0mm, 0mm), radius=TubingRadius+TubingThickness, height=TubingHeight)
  TubingCenter = cylinder(axis=Z, base_centre=(0mm, 0mm, 0mm), radius=TubingRadius, height=TubingHeight)
  Tubing.subtract(TubingCenter)
  TubingCoaxGap = cylinder(axis=X, base_centre=(-(TubingRadius + TubingThickness + AntennaTubingSpace), 0mm, TubingHeight/2), radius=(OuterCoaxDiameter/2) + AntennaTubingSpace, height=(TubingRadius + TubingThickness + AntennaTubingSpace)*2)
  Tubing.subtract(TubingCoaxGap)
  InnerCoaxFinal [pec] = cylinder(axis=X, base_centre=(-(TubingRadius + TubingThickness + AntennaTubingSpace), 0mm, TubingHeight/2), radius=InnerCoaxDiameter/2, height=(TubingRadius + TubingThickness + AntennaTubingSpace)*2)
  InnerCoax2_1 = InnerCoaxFinal.copy()
  InnerCoax2_2 = InnerCoaxFinal.copy()
  InnerCoax = cylinder(axis=Z, base_centre=(0in, 0in, 0in), radius=InnerCoaxDiameter/2, height=TubingHeight/2)
  InnerCoax_1 = InnerCoax.copy()
  InnerCoax_2 = InnerCoax.copy()
  InnerCoaxFinal.unite(InnerCoax)
  InnerCoaxFinal_1 = InnerCoaxFinal.copy()
  InnerCoaxFinal_2 = InnerCoaxFinal.copy()
  InnerCoaxFinal_3 = InnerCoaxFinal.copy()
  DielectricCoaxFinal [vacuum] = cylinder(axis=X, base_centre=(-(TubingRadius + TubingThickness + AntennaTubingSpace), 0mm, TubingHeight/2), radius=DielectricCoaxDiameter/2, height=(TubingRadius + TubingThickness + AntennaTubingSpace)*2)
  DielectricCoax = cylinder(axis=Z, base_centre=(0in, 0in, 0in), radius=DielectricCoaxDiameter/2, height=TubingHeight/2)
  DielectricCoax.subtract(InnerCoax_1)
  DielectricCoax_1 = DielectricCoax.copy()
  DielectricCoax.subtract(InnerCoax2_1)
  DielectricCoaxFinal.unite(DielectricCoax)
  DielectricCoaxFinal.subtract(InnerCoaxFinal_1)
  DielectricCoaxFinal_1 = DielectricCoaxFinal.copy()
  AntennaPosGap = torus(axis=Z, centre=(0mm, 0mm, TubingHeight/2), major_radius=TubingRadius + TubingThickness + AntennaTubingSpace, minor_radius=AntennaWireRadius +AntennaTubingSpace)
  AntennaRemovalPos3 = box(corner=(AntennaCoverOffset, 0mm, 0mm), size=(-1000mm, -1000mm, TubingHeight))
  AntennaRemovalPos2 = box(corner=(-AntennaCoverOffset, 0mm, 0mm), size=(1000mm, 1000mm, TubingHeight))
  AntennaRemovalPos3.unite(AntennaRemovalPos2)
  AntennaPosGap.subtract(AntennaRemovalPos3)
  AntennaPosGap_1 = AntennaPosGap.copy()
  DielectricCoaxFinal.subtract(AntennaPosGap_1)
  OutterCoaxFinal [pec] = cylinder(axis=X, base_centre=(-(TubingRadius + TubingThickness + AntennaTubingSpace), 0mm, TubingHeight/2), radius=OuterCoaxDiameter/2, height=(TubingRadius + TubingThickness + AntennaTubingSpace)*2)
  OutterCoax = cylinder(axis=Z, base_centre=(0in, 0in, 0in), radius=OuterCoaxDiameter/2, height=TubingHeight/2)
  OutterCoax.subtract(DielectricCoax_1, InnerCoax_2)
  OutterCoax.subtract(InnerCoax2_2)
  OutterCoaxFinal.unite(OutterCoax)
  OutterCoaxFinal.subtract(DielectricCoaxFinal_1)
  OutterCoaxFinal.subtract(InnerCoaxFinal_2)
  OutterCoaxFinal.subtract(AntennaPosGap)
  OutterCoaxFinal_1 = OutterCoaxFinal.copy()
  AntennaPos [pec] = torus(axis=Z, centre=(0mm, 0mm, TubingHeight/2), major_radius=TubingRadius + TubingThickness + AntennaTubingSpace, minor_radius=AntennaWireRadius)
  AntennaRemovalPos1 = box(corner=(AntennaCoverOffset, 0mm, 0mm), size=(-1000mm, -1000mm, TubingHeight))
  AntennaRemovalPos = box(corner=(-AntennaCoverOffset, 0mm, 0mm), size=(1000mm, 1000mm, TubingHeight))
  AntennaRemovalPos1.unite(AntennaRemovalPos)
  AntennaPos.subtract(AntennaRemovalPos1)
  AntennaPos.subtract(InnerCoaxFinal_3)
  AntennaNeg [pec] = torus(axis=Z, centre=(0mm, 0mm, TubingHeight/2), major_radius=TubingRadius + TubingThickness + AntennaTubingSpace, minor_radius=AntennaWireRadius)
  AntennaRemovalNeg1 = box(corner=(AntennaCoverOffset - DielectricCoaxDiameter/2, 0mm, 0mm), size=(-1000mm, 1000mm, TubingHeight))
  AntennaRemovalNeg = box(corner=(-AntennaCoverOffset + DielectricCoaxDiameter, 0mm, 0mm), size=(1000mm, -1000mm, TubingHeight))
  AntennaRemovalNeg1.unite(AntennaRemovalNeg)
  AntennaNeg.subtract(AntennaRemovalNeg1)
  DielectricCoaxFinal1 = cylinder(axis=X, base_centre=(-(TubingRadius + TubingThickness + AntennaTubingSpace + 20), 0mm, TubingHeight/2), radius=DielectricCoaxDiameter/2, height=(TubingRadius + TubingThickness + AntennaTubingSpace + 20)*2)
  DielectricCoax1 = cylinder(axis=Z, base_centre=(0in, 0in, 0in), radius=DielectricCoaxDiameter/2, height=TubingHeight/2)
  InnerCoax1 = cylinder(axis=Z, base_centre=(0in, 0in, 0in), radius=InnerCoaxDiameter/2, height=TubingHeight/2)
  InnerCoax_3 = InnerCoax1.copy()
  DielectricCoax1.subtract(InnerCoax_3)
  InnerCoaxFinal1 = cylinder(axis=X, base_centre=(-(TubingRadius + TubingThickness + AntennaTubingSpace + 20), 0mm, TubingHeight/2), radius=InnerCoaxDiameter/2, height=(TubingRadius + TubingThickness + AntennaTubingSpace + 20)*2)
  InnerCoax2_3 = InnerCoaxFinal1.copy()
  DielectricCoax1.subtract(InnerCoax2_3)
  DielectricCoaxFinal1.unite(DielectricCoax1)
  InnerCoaxFinal1.unite(InnerCoax1)
  InnerCoaxFinal_4 = InnerCoaxFinal1.copy()
  DielectricCoaxFinal1.subtract(InnerCoaxFinal_4)
  AntennaNeg.subtract(DielectricCoaxFinal1, InnerCoaxFinal1)
  AntennaNeg.subtract(OutterCoaxFinal_1)
boundaries and excitations:
  Rad1: Radiation Objects=RadiatingSurface
  1: Wave Port Faces=DielectricCoaxFinal.face(at (0, 0, 0)) WavePortType=Modal NumModes=1 Modes{Mode1{CharImp=Zpi}}
setups:
  Setup1: HfssDrivenAuto AutoSolverSetting=Balanced InfiniteSphereSetup=1 Type=Interpolating
    sweep Sweep: 815MHz to 1015MHz, 501 points;
source amplitudes:
  1:1: 1V 0deg
radiation setups:
  Infinite Sphere1: Infinite Sphere Theta=0deg..180deg step 2deg Phi=-180deg..180deg step 2deg
reports:
  Gain Plot 1: dB(GainTotal) vs Phi, Theta on Setup1 : LastAdaptive, Infinite Sphere1 [Freq=0.915GHz]
