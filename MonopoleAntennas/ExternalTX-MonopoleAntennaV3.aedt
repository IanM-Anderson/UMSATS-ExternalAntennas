# Ansys Electronics Desktop project, version 2024.2
materials:
  vacuum: permittivity=1
  Carbon Fiber: permittivity=9 conductivity=100000 dielectric_loss_tangent=0.05 delta_H_freq=915000000
  pec: conductivity=1e+30

design HFSSDesign1 (HFSS, HFSS Terminal Network, model units mm)
variables:
  OuterCoaxDiameter = 4.12mm
  TubingThickness = 2mm
  TubingRadius = 3in
  AntennaTubingSpace = 2mm
  TubingHeight = 200mm
  InnerCoaxDiameter = 1.12mm
  DielectricCoaxDiameter = 3mm
  SpeedOfLight = 300000000m_per_sec
  Period = 1.1e-09s
  MonopoleLength = (SpeedOfLight*Period/2) meter
  AntennaWireRadius = 0.6mm
  AntennaRadius = TubingRadius + TubingThickness + AntennaTubingSpace
  AntennaCoverOffset = AntennaRadius*cos((MonopoleLength/AntennaRadius)) meter
  RadiatingSurface_Z = 200mm
  RadiatingSurface_Y = 200mm
  RadiatingSurface_X = 300mm
  CoaxGap = 30mm
geometry:
  Tubing [Carbon Fiber, solve inside] = cylinder(axis=Z, base_centre=(0mm, 0mm, 0mm), radius=TubingRadius+TubingThickness, height=TubingHeight)
  TubingCenter = cylinder(axis=Z, base_centre=(0mm, 0mm, 0mm), radius=TubingRadius, height=TubingHeight)
  Tubing.subtract(TubingCenter)
  TubingCoaxGap = cylinder(axis=X, base_centre=(-(TubingRadius + TubingThickness + AntennaTubingSpace), 0mm, TubingHeight/2), radius=(OuterCoaxDiameter/2), height=(TubingRadius + TubingThickness + AntennaTubingSpace)*2)
  Tubing.subtract(TubingCoaxGap)
  InnerCoax0 [pec] = cylinder(axis=X, base_centre=(-AntennaRadius, 0mm, TubingHeight/2), radius=InnerCoaxDiameter/2, height=AntennaRadius - CoaxGap)
  InnerCoaxFinal_1 = InnerCoax0.copy()
  InnerCoaxFinal_2 = InnerCoax0.copy()
  InnerCoaxFinal_3 = InnerCoax0.copy()
  DielectricCoax0 [vacuum] = cylinder(axis=X, base_centre=(-(TubingRadius + TubingThickness), 0mm, TubingHeight/2), radius=DielectricCoaxDiameter/2, height=(TubingRadius + TubingThickness) - CoaxGap)
  DielectricCoax0.subtract(InnerCoaxFinal_1)
  DielectricCoaxFinal_1 = DielectricCoax0.copy()
  OutterCoaxFinal [pec] = cylinder(axis=X, base_centre=(-(TubingRadius + TubingThickness), 0mm, TubingHeight/2), radius=OuterCoaxDiameter/2, height=(TubingRadius + TubingThickness) - CoaxGap)
  OutterCoaxFinal.subtract(DielectricCoaxFinal_1)
  OutterCoaxFinal.subtract(InnerCoaxFinal_2)
  AntennaPos [pec] = torus(axis=Z, centre=(0mm, 0mm, TubingHeight/2), major_radius=AntennaRadius, minor_radius=AntennaWireRadius)
  AntennaRemovalPos1 = box(corner=(AntennaCoverOffset, 0mm, 0mm), size=(-1000mm, -1000mm, TubingHeight))
  AntennaRemovalPos = box(corner=(-AntennaCoverOffset, 0mm, 0mm), size=(1000mm, 1000mm, TubingHeight))
  AntennaRemovalPos1.unite(AntennaRemovalPos)
  AntennaPos.subtract(AntennaRemovalPos1)
  AntennaPos.subtract(InnerCoaxFinal_3)
  RadiatingSurface [vacuum] = box(corner=(-RadiatingSurface_X/2, -RadiatingSurface_Y/2, 0mm), size=(RadiatingSurface_X, RadiatingSurface_Y, RadiatingSurface_Z))
  InnerCoax180 [pec] = cylinder(axis=X, base_centre=(CoaxGap, 0mm, TubingHeight/2), radius=InnerCoaxDiameter/2, height=AntennaRadius - CoaxGap)
  DielectricCoax180 [vacuum] = cylinder(axis=X, base_centre=(CoaxGap, 0mm, TubingHeight/2), radius=DielectricCoaxDiameter/2, height=TubingRadius + TubingThickness - CoaxGap)
  InnerCoax180_1 = InnerCoax180.copy()
  DielectricCoax180.subtract(InnerCoax180_1)
  OutterCoax180 [pec] = cylinder(axis=X, base_centre=(CoaxGap, 0mm, TubingHeight/2), radius=OuterCoaxDiameter/2, height=TubingRadius + TubingThickness - CoaxGap)
  DielectricCoax180_1 = DielectricCoax180.copy()
  InnerCoax180_2 = InnerCoax180.copy()
  OutterCoax180.subtract(DielectricCoax180_1, InnerCoax180_2)
  InnerCoax180_3 = InnerCoax180.copy()
  AntennaPos.subtract(InnerCoax180_3)
boundaries and excitations:
  Rad1: Radiation Objects=RadiatingSurface
  2: Lumped Port Faces=DielectricCoax0.face(+x end) LumpedPortType=Modal Modes{Mode1{IntLine{(-30, 0.56, 100) -> (-30, 1.5, 100)} CharImp=Zpi}} Impedance=50ohm
  1: Lumped Port Faces=DielectricCoax180.face(-x end) LumpedPortType=Modal Modes{Mode1{IntLine{(30, 0.56, 100) -> (30, 1.5, 100)} CharImp=Zpi}} Impedance=50ohm
  reference conductors: OutterCoax180
setups:
  Setup1: HfssDrivenAuto AutoSolverSetting=Balanced InfiniteSphereSetup=1 Type=Interpolating
    sweep Sweep: 815MHz to 1015MHz, 501 points;
source amplitudes:
  2:1: 1W 0deg
  1:1: 1W 180deg
radiation setups:
  Infinite Sphere1: Infinite Sphere Theta=0deg..180deg step 2deg Phi=-180deg..180deg step 2deg
