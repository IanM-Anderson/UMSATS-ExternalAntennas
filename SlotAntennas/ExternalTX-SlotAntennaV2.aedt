# Ansys Electronics Desktop project, version 2024.2
materials:
  vacuum: permittivity=1
  pec: conductivity=1e+30
  Carbon Fiber: permittivity=9 conductivity=100000 dielectric_loss_tangent=0.05 delta_H_freq=915000000

design HFSSDesign1 (HFSS, HFSS Terminal Network, model units mm)
variables:
  TubingRadius = 3in
  TubingHeight = 200mm
  TubingThickness = 2mm
  DielectricLayerThickness = 0.4mm
  ConductiveLayerThickness = 0.4mm
  SlotWidth = 4mm
  TotalRadius = (TubingRadius + TubingThickness + DielectricLayerThickness + ConductiveLayerThickness) meter
  SpeedofLight = 300000000m_per_sec
  Period = 1.09e-09s
  SlotLength = ((SpeedofLight*Period)/2) meter
  SlotOffset = TotalRadius*cos((SlotLength/2)/TotalRadius) meter
  InnerCoaxRadius = 0.6mm
  DielectricCoaxRadius = InnerCoaxRadius + 1.2mm
  OuterCoaxRadius = DielectricCoaxRadius + 0.6mm
  CoaxGap = 2mm
  WireRadius = 0.6mm
  RadiationX = 200mm
  RadiationY = 200mm
  RadiationZ = 200mm
geometry:
  TubingInner = cylinder(axis=Z, base_centre=(0mm, 0mm, 0mm), radius=TubingRadius, height=TubingHeight)
  Tubing [pec] = cylinder(axis=Z, base_centre=(0mm, 0mm, 0mm), radius=TubingRadius + TubingThickness, height=TubingHeight)
  DielectricLayer [vacuum] = cylinder(axis=Z, base_centre=(0mm, 0mm, 0mm), radius=TubingRadius + TubingThickness + DielectricLayerThickness, height=TubingHeight)
  TubingInner_1 = TubingInner.copy()
  Tubing.subtract(TubingInner_1)
  Tubing_1 = Tubing.copy()
  TubingInner_2 = TubingInner.copy()
  DielectricLayer.subtract(Tubing_1, TubingInner_2)
  ConductiveLayer [pec] = cylinder(axis=Z, base_centre=(0mm, 0mm, 0mm), radius=TubingRadius + TubingThickness + DielectricLayerThickness + ConductiveLayerThickness, height=TubingHeight)
  DielectricLayer_1 = DielectricLayer.copy()
  Tubing_2 = Tubing.copy()
  TubingInner_3 = TubingInner.copy()
  TubingInner.delete()
  ConductiveLayer.subtract(DielectricLayer_1, Tubing_2, TubingInner_3)
  Slot1 = box(corner=(SlotOffset, -TotalRadius, TubingHeight/2), size=(2*TotalRadius, 2*TotalRadius, SlotWidth))
  Slot2 = box(corner=(-SlotOffset, -TotalRadius, TubingHeight/2), size=(-2*TotalRadius, 2*TotalRadius, SlotWidth))
  ConductiveLayer.subtract(Slot1, Slot2)
  InnerCoax [pec] = cylinder(axis=Z, base_centre=(0mm, 0mm, 0mm), radius=InnerCoaxRadius, height=TubingHeight/2)
  DielectricCoax [vacuum] = cylinder(axis=Z, base_centre=(0mm, 0mm, 0mm), radius=DielectricCoaxRadius, height=TubingHeight/2)
  OuterCoax [pec] = cylinder(axis=Z, base_centre=(0mm, 0mm, 0mm), radius=OuterCoaxRadius, height=TubingHeight/2)
  DielectricCoax_Center_1 = DielectricCoax.copy()
  InnerCoax_Center_1 = InnerCoax.copy()
  OuterCoax.subtract(DielectricCoax_Center_1, InnerCoax_Center_1)
  InnerCoax_Center_2 = InnerCoax.copy()
  DielectricCoax.subtract(InnerCoax_Center_2)
  InnerCoax_Sides = cylinder(axis=X, base_centre=(-(TubingRadius+TubingThickness+DielectricLayerThickness), 0mm, TubingHeight/2), radius=InnerCoaxRadius, height=2*(TubingRadius+TubingThickness+DielectricLayerThickness))
  InnerCoax_Sides_Gap = cylinder(axis=X, base_centre=(-(TubingRadius+TubingThickness+DielectricLayerThickness), 0mm, TubingHeight/2), radius=InnerCoaxRadius + CoaxGap, height=2*(TubingRadius+TubingThickness+DielectricLayerThickness))
  InnerCoax_Sides_Gap_1 = InnerCoax_Sides_Gap.copy()
  Tubing.subtract(InnerCoax_Sides_Gap_1)
  DielectricLayer.subtract(InnerCoax_Sides_Gap)
  DielectricCoax_Sides = cylinder(axis=X, base_centre=(-(TubingRadius+TubingThickness), 0mm, TubingHeight/2), radius=DielectricCoaxRadius, height=2*(TubingRadius+TubingThickness))
  OuterCoax_Sides = cylinder(axis=X, base_centre=(-TubingRadius, 0mm, TubingHeight/2), radius=OuterCoaxRadius, height=2*TubingRadius)
  InnerCoax_Sides_1 = InnerCoax_Sides.copy()
  InnerCoax.subtract(InnerCoax_Sides_1)
  OuterCoax_Sides_1 = OuterCoax_Sides.copy()
  OuterCoax.subtract(OuterCoax_Sides_1)
  DielectricCoax_Sides_1 = DielectricCoax_Sides.copy()
  DielectricCoax.subtract(DielectricCoax_Sides_1)
  DielectricCoax_Sides_2 = DielectricCoax_Sides.copy()
  InnerCoax_Sides_2 = InnerCoax_Sides.copy()
  OuterCoax_Sides.subtract(DielectricCoax_Sides_2, InnerCoax_Sides_2)
  InnerCoax_Sides_3 = InnerCoax_Sides.copy()
  DielectricCoax_Sides.subtract(InnerCoax_Sides_3)
  DielectricCoax_Center_2 = DielectricCoax.copy()
  InnerCoax_Center_3 = InnerCoax.copy()
  OuterCoax_Sides.subtract(DielectricCoax_Center_2, InnerCoax_Center_3)
  InnerCoax_Center_4 = InnerCoax.copy()
  DielectricCoax_Sides.subtract(InnerCoax_Center_4)
  ConductiveLayer_1 = ConductiveLayer.copy()
  InnerCoax_Sides.subtract(ConductiveLayer_1)
  InnerCoax.unite(InnerCoax_Sides)
  OuterCoax.unite(OuterCoax_Sides)
  DielectricCoax.unite(DielectricCoax_Sides)
  OuterCoaxWireVert = cylinder(axis=Z, base_centre=((TubingRadius - CoaxGap - WireRadius), 0mm, TubingHeight/2 + OuterCoaxRadius), radius=WireRadius, height=SlotWidth - OuterCoaxRadius)
  OuterCoaxWire [pec] = cylinder(axis=X, base_centre=(TubingRadius - CoaxGap - WireRadius, 0mm, TubingHeight/2 + SlotWidth), radius=WireRadius, height=(CoaxGap + WireRadius + TubingThickness +DielectricLayerThickness))
  OuterCoaxWireHor_1 = OuterCoaxWire.copy()
  DielectricLayer.subtract(OuterCoaxWireHor_1)
  OuterCoaxWireHor_2 = OuterCoaxWire.copy()
  Tubing.subtract(OuterCoaxWireHor_2)
  ConductiveLayer_2 = ConductiveLayer.copy()
  OuterCoaxWire.subtract(ConductiveLayer_2)
  OuterCoaxWire.unite(OuterCoaxWireVert)
  OuterCoaxWire1 [pec] = cylinder(axis=X, base_centre=(-(TubingRadius - CoaxGap - WireRadius), 0mm, TubingHeight/2 + SlotWidth), radius=WireRadius, height=-(CoaxGap + WireRadius + TubingThickness +DielectricLayerThickness))
  ConductiveLayer1 = cylinder(axis=Z, base_centre=(0mm, 0mm, 0mm), radius=TubingRadius + TubingThickness + DielectricLayerThickness + ConductiveLayerThickness, height=TubingHeight)
  DielectricLayer1 = cylinder(axis=Z, base_centre=(0mm, 0mm, 0mm), radius=TubingRadius + TubingThickness + DielectricLayerThickness, height=TubingHeight)
  Tubing1 = cylinder(axis=Z, base_centre=(0mm, 0mm, 0mm), radius=TubingRadius + TubingThickness, height=TubingHeight)
  TubingInner1 = cylinder(axis=Z, base_centre=(0mm, 0mm, 0mm), radius=TubingRadius, height=TubingHeight)
  TubingInner_4 = TubingInner1.copy()
  Tubing1.subtract(TubingInner_4)
  Tubing_3 = Tubing1.copy()
  TubingInner_5 = TubingInner1.copy()
  DielectricLayer1.subtract(Tubing_3, TubingInner_5)
  DielectricLayer_2 = DielectricLayer1.copy()
  Tubing_4 = Tubing1.copy()
  TubingInner_6 = TubingInner1.copy()
  ConductiveLayer1.subtract(DielectricLayer_2, Tubing_4, TubingInner_6)
  Slot3 = box(corner=(SlotOffset, -TotalRadius, TubingHeight/2), size=(2*TotalRadius, 2*TotalRadius, SlotWidth))
  Slot4 = box(corner=(-SlotOffset, -TotalRadius, TubingHeight/2), size=(-2*TotalRadius, 2*TotalRadius, SlotWidth))
  ConductiveLayer1.subtract(Slot3, Slot4)
  ConductiveLayer_3 = ConductiveLayer1.copy()
  OuterCoaxWire1.subtract(ConductiveLayer_3)
  [TubingInner1, Tubing1, DielectricLayer1, ConductiveLayer1].delete()
  OuterCoaxWireVert1 = cylinder(axis=Z, base_centre=(-(TubingRadius - CoaxGap - WireRadius), 0mm, TubingHeight/2 + OuterCoaxRadius), radius=WireRadius, height=SlotWidth - OuterCoaxRadius)
  OuterCoaxWire1.unite(OuterCoaxWireVert1)
  OuterCoaxWire1_1 = OuterCoaxWire1.copy()
  DielectricLayer.subtract(OuterCoaxWire1_1)
  OuterCoaxWire1_2 = OuterCoaxWire1.copy()
  Tubing.subtract(OuterCoaxWire1_2)
  CoaxCover [pec] = cylinder(axis=Z, base_centre=(0mm, 0mm, 0mm), radius=OuterCoaxRadius, height=-2mm)
  RadiationBoxx [vacuum] = box(corner=(-RadiationX, -RadiationY, 0mm), size=(2*RadiationX, 2*RadiationY, RadiationZ))
boundaries and excitations:
  Rad1: Radiation Objects=RadiationBoxx
  1: Wave Port Faces=DielectricCoax.face(-z end) WavePortType=Modal NumModes=1 Modes{Mode1{IntLine{(0, -0.6, 0) -> (0, -1.8, 0)} CharImp=Zpi}}
setups:
  Setup1: HfssDrivenAuto AutoSolverSetting=Balanced InfiniteSphereSetup=1 Type=Interpolating
    sweep Sweep: 815MHz to 1015MHz, 501 points;
source amplitudes:
  1:1: 1V 0deg
radiation setups:
  Infinite Sphere1: Infinite Sphere Theta=0deg..180deg step 2deg Phi=-180deg..180deg step 2deg
reports:
  Gain Plot 1: dB(GainTotal) vs Phi, Theta on Setup1 : LastAdaptive, Infinite Sphere1 [Freq=0.915GHz]
